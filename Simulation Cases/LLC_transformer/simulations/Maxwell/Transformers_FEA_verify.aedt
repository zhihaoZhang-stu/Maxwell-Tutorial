# Ansys Electronics Desktop project, version 2025.1
materials:
  vacuum: permittivity=1
  TDK_PC95_60cel_BH: core_loss_curve{50kHz (0, 0) (0.049862966, 4.1005345) (0.060258577, 6.8639779) (0.069693025, 9.604843) (0.079288168, 12.85137) (0.089957123, 17.195253) (0.10011968, 22.497801) (0.13429265, 48.181396) (0.19992957, 126.23138) (0.24094943, 202.0447) (0.30010796, 361.71437)} core_loss_curve{100kHz (0, 0) (0.05, 11.750028) (0.059928731, 18.390411) (0.069311536, 26.316823) (0.079506068, 36.825433) (0.090204344, 49.272773) (0.10039483, 64.467157) (0.12000091, 98.665069) (0.15876613, 193.19337) (0.19938163, 330.71604) (0.23897376, 506.15107) (0.29928546, 906.14655)} core_loss_curve{200kHz (0, 0) (0.05, 31.481432) (0.060258577, 50.388871) (0.069693025, 68.947957) (0.079724568, 96.479667) (0.089957123, 129.0907) (0.10067074, 172.72456) (0.13765098, 386.85538) (0.20047902, 947.6625) (0.2490168, 1586.3138) (0.29928546, 2482.7994)} core_loss_curve{300kHz (0, 0) (0.049862966, 63.039229) (0.060093428, 100.89997) (0.069502019, 144.38866) (0.079724568, 197.56947) (0.08971058, 264.3498) (0.10039483, 345.8681) (0.12712013, 605.4819) (0.15446813, 991.08054) (0.19883519, 1897.6238) (0.23963051, 2904.2568) (0.30093272, 4861.5015)} permeability{HUnit=A_per_meter BUnit=tesla curve (0, 0) (17.20430108, 0.079976243) (32.49701314, 0.199539595) (49.70131422, 0.297790055) (64.09402628, 0.349834622) (76.46356033, 0.383911602) (89.84468339, 0.412285451) (107.0489845, 0.436556169) (135.7228196, 0.45174954) (168.2198327, 0.462891344) (202.6284349, 0.471007366) (250.4181601, 0.478084715) (298.2078853, 0.481123389) (498.9247312, 0.486187845) (1282.676225, 0.491252302) (2560, 0.4934)} conductivity=0.167 saturation_mag=0.48tesla core_loss_type="Power Ferrite" core_loss_cm=0.59673882 core_loss_x=1.4941961 core_loss_y=2.4413048 mass_density=4900
  copper: permeability=0.999991 conductivity=58000000
  air: permittivity=1.0006 permeability=1.0000004
  ML91S: permeability{HUnit=A_per_meter BUnit=mTesla curve (0, 0) (10, 15) (20, 29) (30, 44) (40, 59) (50, 75) (60, 92) (70, 111) (80, 134) (90, 160) (100, 187) (120, 251) (140, 303) (160, 345) (180, 382) (200, 410) (250, 451) (300, 472) (350, 485) (400, 494) (450, 500) (500, 505) (600, 514) (700, 519) (800, 523) (900, 526) (1000, 529)} conductivity=0.125 core_loss_type="Power Ferrite" core_loss_cm=0.00649 core_loss_x=1.938 core_loss_y=3.335 mass_density=4850

design Trans1 (Maxwell 3D, EddyCurrent, model units mm)
variables:
  Lg = 0.045mm
geometry:
  core_1, core [TDK_PC95_60cel_BH] = imported_body(C:\Users\16491\Desktop\HW_Trans\LLC_trans3.sat)
  S_2 [copper] = imported_body(C:\Users\16491\Desktop\HW_Trans\LLC_trans3.sat)
  LLC_trans3_Unnamed_6 = imported_body(C:\Users\16491\Desktop\HW_Trans\LLC_trans3.sat)
  core_3, core_4, core_2 [TDK_PC95_60cel_BH] = imported_body(C:\Users\16491\Desktop\HW_Trans\LLC_trans3.sat)
  P_4 [copper] = imported_body(C:\Users\16491\Desktop\HW_Trans\LLC_trans3.sat)
  LLC_trans3_Unnamed_17 = imported_body(C:\Users\16491\Desktop\HW_Trans\LLC_trans3.sat)
  P_5 [copper] = imported_body(C:\Users\16491\Desktop\HW_Trans\LLC_trans3.sat)
  LLC_trans3_Unnamed_19 = imported_body(C:\Users\16491\Desktop\HW_Trans\LLC_trans3.sat)
  [core_1, core, S_2, LLC_trans3_Unnamed_6, core_3, core_4, core_2, P_4, LLC_trans3_Unnamed_17, P_5, LLC_trans3_Unnamed_19].move(-532.02256mm, -238.98427mm, 0mm)
  [core_1, core, S_2, LLC_trans3_Unnamed_6, core_3, core_4, core_2, P_4, LLC_trans3_Unnamed_17, P_5, LLC_trans3_Unnamed_19].rotate(axis=Z, angle=90deg)
  core_4.sweep_along_vector((0mm, 0mm, 0.003-Lg))
  core.sweep_along_vector((0mm, 0mm, 3mm))
  [core_2, core_3].sweep_along_vector((0mm, 0mm, 0.003-Lg))
  core_1.sweep_along_vector((0mm, 0mm, 3mm))
  P_4.subtract(LLC_trans3_Unnamed_17)
  S_2.subtract(LLC_trans3_Unnamed_19)
  P_5.subtract(LLC_trans3_Unnamed_6)
  S, S_1 [copper] = S_2.duplicate_along_line(step=(0mm, 13.3mm, 4.4408921e-16mm), total=3)
  P, P_1 [copper] = P_4.duplicate_along_line(step=(0mm, 13.3mm, 4.4408921e-16mm), total=3)
  P_2, P_3 [copper] = P_5.duplicate_along_line(step=(0mm, 13.3mm, 4.4408921e-16mm), total=3)
  [S_2, S, S_1].sweep_along_vector((0mm, 0mm, 0.035mm))
  [S_2, S, S_1].move(0mm, 0mm, 2.4mm)
  S_2_1 = S_2.duplicate_along_line(step=(0mm, 0mm, 0.035mm), total=2)
  S_3 = S.duplicate_along_line(step=(0mm, 0mm, 0.035mm), total=2)
  S_1_1 = S_1.duplicate_along_line(step=(0mm, 0mm, 0.035mm), total=2)
  S_2_2 = S_2.duplicate_along_line(step=(0mm, 0mm, -0.035mm), total=2)
  S_4 = S.duplicate_along_line(step=(0mm, 0mm, -0.035mm), total=2)
  S_1_2 = S_1.duplicate_along_line(step=(0mm, 0mm, -0.035mm), total=2)
  S_2_3 [copper] = S_2.duplicate_along_line(step=(0mm, 0mm, -0.4mm), total=2)
  S_5 [copper] = S.duplicate_along_line(step=(0mm, 0mm, -0.4mm), total=2)
  S_1_3 [copper] = S_1.duplicate_along_line(step=(0mm, 0mm, -0.4mm), total=2)
  S_2_4 = S_2.duplicate_along_line(step=(0mm, 0mm, -0.435mm), total=2)
  S_6 = S.duplicate_along_line(step=(0mm, 0mm, -0.435mm), total=2)
  S_1_4 = S_1.duplicate_along_line(step=(0mm, 0mm, -0.435mm), total=2)
  S_1.unite(S_1_1, S_1_2)
  S_1_3.unite(S_1_4)
  S.unite(S_3, S_4)
  S_5.unite(S_6)
  S_2.unite(S_2_1, S_2_2)
  S_2_3.unite(S_2_4)
  [P_4, P_5, P, P_2, P_1, P_3].sweep_along_vector((0mm, 0mm, 0.07mm))
  [P_4, P_5, P, P_2, P_1, P_3].move(0mm, 0mm, 1.6mm)
  S_2_5 [copper] = S_2.duplicate_mirror(point=(0mm, 6.85mm, 1.4mm), normal=(0mm, 0mm, -1mm))
  P_4_1 [copper] = P_4.duplicate_mirror(point=(0mm, 6.85mm, 1.4mm), normal=(0mm, 0mm, -1mm))
  P_5_1 [copper] = P_5.duplicate_mirror(point=(0mm, 6.85mm, 1.4mm), normal=(0mm, 0mm, -1mm))
  S_7 [copper] = S.duplicate_mirror(point=(0mm, 6.85mm, 1.4mm), normal=(0mm, 0mm, -1mm))
  S_1_5 [copper] = S_1.duplicate_mirror(point=(0mm, 6.85mm, 1.4mm), normal=(0mm, 0mm, -1mm))
  P_6 [copper] = P.duplicate_mirror(point=(0mm, 6.85mm, 1.4mm), normal=(0mm, 0mm, -1mm))
  P_1_1 [copper] = P_1.duplicate_mirror(point=(0mm, 6.85mm, 1.4mm), normal=(0mm, 0mm, -1mm))
  P_2_1 [copper] = P_2.duplicate_mirror(point=(0mm, 6.85mm, 1.4mm), normal=(0mm, 0mm, -1mm))
  P_3_1 [copper] = P_3.duplicate_mirror(point=(0mm, 6.85mm, 1.4mm), normal=(0mm, 0mm, -1mm))
  S_2_3_1 [copper] = S_2_3.duplicate_mirror(point=(0mm, 6.85mm, 1.4mm), normal=(0mm, 0mm, -1mm))
  S_5_1 [copper] = S_5.duplicate_mirror(point=(0mm, 6.85mm, 1.4mm), normal=(0mm, 0mm, -1mm))
  S_1_3_1 [copper] = S_1_3.duplicate_mirror(point=(0mm, 6.85mm, 1.4mm), normal=(0mm, 0mm, -1mm))
  core_5 [TDK_PC95_60cel_BH] = box(corner=(-9.5mm, -23.5mm, 3mm), size=(19mm, 47mm, 3mm))
  core_5_1 [TDK_PC95_60cel_BH] = core_5.duplicate_along_line(step=(1.9539925e-14mm, -2.3092639e-13mm, -6mm), total=2)
  S_2_Section1 = S_2.section(plane=YZ)
  P_4_Section1 [copper] = P_4.section(plane=YZ)
  P_5_Section1 [copper] = P_5.section(plane=YZ)
  S_Section1 = S.section(plane=YZ)
  S_1_Section1 = S_1.section(plane=YZ)
  P_Section1 [copper] = P.section(plane=YZ)
  P_1_Section1 [copper] = P_1.section(plane=YZ)
  P_2_Section1 [copper] = P_2.section(plane=YZ)
  P_3_Section1 [copper] = P_3.section(plane=YZ)
  S_2_3_Section1 = S_2_3.section(plane=YZ)
  S_5_Section1 = S_5.section(plane=YZ)
  S_1_3_Section1 = S_1_3.section(plane=YZ)
  S_2_5_Section1 [copper] = S_2_5.section(plane=YZ)
  P_4_1_Section1 [copper] = P_4_1.section(plane=YZ)
  P_5_1_Section1 [copper] = P_5_1.section(plane=YZ)
  S_7_Section1 [copper] = S_7.section(plane=YZ)
  S_1_5_Section1 [copper] = S_1_5.section(plane=YZ)
  P_6_Section1 [copper] = P_6.section(plane=YZ)
  P_1_1_Section1 [copper] = P_1_1.section(plane=YZ)
  P_2_1_Section1 [copper] = P_2_1.section(plane=YZ)
  P_3_1_Section1 [copper] = P_3_1.section(plane=YZ)
  S_2_3_1_Section1 [copper] = S_2_3_1.section(plane=YZ)
  S_5_1_Section1 [copper] = S_5_1.section(plane=YZ)
  S_1_3_1_Section1 [copper] = S_1_3_1.section(plane=YZ)
  S_2_Section1_Separate1 [copper] = S_2_Section1.separate_bodies()
  S_2_Section1.delete()
  P_4_Section1.separate_bodies()
  P_5_Section1.separate_bodies()
  S_Section1_Separate1 [copper] = S_Section1.separate_bodies()
  S_Section1.delete()
  S_1_Section1_Separate1 [copper] = S_1_Section1.separate_bodies()
  S_1_Section1.delete()
  P_Section1.separate_bodies()
  P_1_Section1.separate_bodies()
  P_2_Section1.separate_bodies()
  P_3_Section1.separate_bodies()
  S_2_3_Section1_Separate1 [copper] = S_2_3_Section1.separate_bodies()
  S_2_3_Section1.delete()
  S_5_Section1_Separate1 [copper] = S_5_Section1.separate_bodies()
  S_5_Section1.delete()
  S_1_3_Section1_Separate1 [copper] = S_1_3_Section1.separate_bodies()
  S_1_3_Section1.delete()
  S_2_5_Section1.separate_bodies()
  P_4_1_Section1.separate_bodies()
  P_5_1_Section1.separate_bodies()
  S_7_Section1.separate_bodies()
  S_1_5_Section1.separate_bodies()
  P_6_Section1.separate_bodies()
  P_1_1_Section1.separate_bodies()
  P_2_1_Section1.separate_bodies()
  P_3_1_Section1.separate_bodies()
  S_2_3_1_Section1.separate_bodies()
  S_5_1_Section1.separate_bodies()
  S_1_3_1_Section1.separate_bodies()
  Region [vacuum] = region(percentage_offset: +X=100, -X=100, +Y=50, -Y=50, +Z=200, -Z=200)
  core_Section1 [ML91S] = core.section(plane=YZ)
  core_1_Section1 [ML91S] = core_1.section(plane=YZ)
  core_2_Section1 [ML91S] = core_2.section(plane=YZ)
  core_3_Section1 [ML91S] = core_3.section(plane=YZ)
  core_4_Section1 [ML91S] = core_4.section(plane=YZ)
  core_5_Section1 [ML91S] = core_5.section(plane=YZ)
  core_5_1_Section1 [ML91S] = core_5_1.section(plane=YZ)
  group LLC_trans4 = core_1, core, S_2, core_3, core_4, core_2, P_4, P_5, S, S_1, P, P_1, P_2, P_3, S_2_3, S_5, S_1_3, S_2_5, P_4_1, P_5_1, S_7, S_1_5, P_6, P_1_1, P_2_1, P_3_1, S_2_3_1, S_5_1, S_1_3_1, core_5, core_5_1, P_4_Section1, P_5_Section1, P_Section1, P_1_Section1, P_2_Section1, P_3_Section1, S_2_5_Section1, P_4_1_Section1, P_5_1_Section1, S_7_Section1, S_1_5_Section1, P_6_Section1, P_1_1_Section1, P_2_1_Section1, P_3_1_Section1, S_2_3_1_Section1, S_5_1_Section1, S_1_3_1_Section1, S_2_Section1_Separate1, S_Section1_Separate1, S_1_Section1_Separate1, S_2_3_Section1_Separate1, S_5_Section1_Separate1, S_1_3_Section1_Separate1, core_Section1, core_1_Section1, core_2_Section1, core_3_Section1, core_4_Section1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
boundaries and excitations:
  CoilTerminal_1: Coil Terminal Objects=P_1_Section1 Conductor_number=1 Winding=P Point_out_of_terminal=false
  CoilTerminal_2: Coil Terminal Objects=P_3_Section1 Conductor_number=1 Winding=P Point_out_of_terminal=false
  CoilTerminal_3: Coil Terminal Objects=P_1_1_Section1 Conductor_number=1 Winding=P Point_out_of_terminal=false
  CoilTerminal_4: Coil Terminal Objects=P_3_1_Section1 Conductor_number=1 Winding=P Point_out_of_terminal=false
  CoilTerminal_5: Coil Terminal Objects=P_Section1 Conductor_number=1 Winding=P Point_out_of_terminal=true
  CoilTerminal_6: Coil Terminal Objects=P_2_Section1 Conductor_number=1 Winding=P Point_out_of_terminal=true
  CoilTerminal_7: Coil Terminal Objects=P_6_Section1 Conductor_number=1 Winding=P Point_out_of_terminal=true
  CoilTerminal_8: Coil Terminal Objects=P_2_1_Section1 Conductor_number=1 Winding=P Point_out_of_terminal=true
  CoilTerminal_9: Coil Terminal Objects=P_4_Section1 Conductor_number=1 Winding=P Point_out_of_terminal=false
  CoilTerminal_10: Coil Terminal Objects=P_5_Section1 Conductor_number=1 Winding=P Point_out_of_terminal=false
  CoilTerminal_11: Coil Terminal Objects=P_4_1_Section1 Conductor_number=1 Winding=P Point_out_of_terminal=false
  CoilTerminal_12: Coil Terminal Objects=P_5_1_Section1 Conductor_number=1 Winding=P Point_out_of_terminal=false
  CoilTerminal_13: Coil Terminal Objects=S_1_Section1_Separate1 Conductor_number=1 Winding=S Point_out_of_terminal=true
  CoilTerminal_14: Coil Terminal Objects=S_1_3_Section1_Separate1 Conductor_number=1 Winding=S Point_out_of_terminal=true
  CoilTerminal_15: Coil Terminal Objects=S_1_5_Section1 Conductor_number=1 Winding=S Point_out_of_terminal=true
  CoilTerminal_16: Coil Terminal Objects=S_1_3_1_Section1 Conductor_number=1 Winding=S Point_out_of_terminal=true
  CoilTerminal_17: Coil Terminal Objects=S_Section1_Separate1 Conductor_number=1 Winding=S Point_out_of_terminal=false
  CoilTerminal_18: Coil Terminal Objects=S_5_Section1_Separate1 Conductor_number=1 Winding=S Point_out_of_terminal=false
  CoilTerminal_19: Coil Terminal Objects=S_7_Section1 Conductor_number=1 Winding=S Point_out_of_terminal=false
  CoilTerminal_20: Coil Terminal Objects=S_5_1_Section1 Conductor_number=1 Winding=S Point_out_of_terminal=false
  CoilTerminal_21: Coil Terminal Objects=S_2_Section1_Separate1 Conductor_number=1 Winding=S Point_out_of_terminal=true
  CoilTerminal_22: Coil Terminal Objects=S_2_3_Section1_Separate1 Conductor_number=1 Winding=S Point_out_of_terminal=true
  CoilTerminal_23: Coil Terminal Objects=S_2_5_Section1 Conductor_number=1 Winding=S Point_out_of_terminal=true
  CoilTerminal_24: Coil Terminal Objects=S_2_3_1_Section1 Conductor_number=1 Winding=S Point_out_of_terminal=true
  P: Winding Group Type=Voltage IsSolid=true Current=0mA Resistance=0.01ohm Inductance=0nH Voltage=420V ParallelBranchesNum=1 Phase=0deg
  S: Winding Group Type=Voltage IsSolid=true Current=0mA Resistance=4.9ohm Inductance=0nH Voltage=0mV ParallelBranchesNum=6 Phase=0deg
  eddy effects on: core_1, core, S_2, core_3, core_4, core_2, P_4, P_5, S, S_1, P, P_1, P_2, P_3, S_2_3, S_5, S_1_3, S_2_5, P_4_1, P_5_1, S_7, S_1_5, P_6, P_1_1, P_2_1, P_3_1, S_2_3_1, S_5_1, S_1_3_1, core_5, core_5_1
  core loss on: core_1, core, core_3, core_4, core_2, core_5, core_5_1
parameters:
  Matrix1: Matrix P, S:
mesh:
  initial mesh: GlobalCurvilinear{Apply}
setups:
  Setup1: EddyCurrent MaximumPasses=8 MinimumPasses=2 MinimumConvergedPasses=1 PercentRefinement=50 PercentError=5 NonLinearResidual=0.0001 Frequency=500kHz LossAdaptiveCtrl=0.5
field plots:
  Mag_B1: B over core, core_1..core_4, core_5_1 on Setup1 : LastAdaptive at Freq=500kHz Phase=0deg
  Mag_B2: B over core_Section1.face core_1_Section1.face core_2_Section1.face core_3_Section1.face core_4_Section1.face core_5_Section1.face core_5_1_Section1.face on Setup1 : LastAdaptive at Freq=500kHz Phase=0deg
  Vector_B1: B over core_Section1.face core_1_Section1.face core_2_Section1.face core_3_Section1.face core_4_Section1.face core_5_1_Section1.face core_5_Section1.face on Setup1 : LastAdaptive at Freq=500kHz Phase=0deg
  Mag_J1: J over P, P_1, P_1_1, P_2, P_2_1, P_3, P_3_1, P_4, P_4_1, P_5, P_5_1, P_6 on Setup1 : LastAdaptive at Freq=500kHz Phase=0deg
  Mag_J2: J over S_2, S_1, S_7 on Setup1 : LastAdaptive at Freq=500kHz Phase=0deg
  Mag_J3: J over S_2_3, S_1_3, S_5_1 on Setup1 : LastAdaptive at Freq=500kHz Phase=0deg
