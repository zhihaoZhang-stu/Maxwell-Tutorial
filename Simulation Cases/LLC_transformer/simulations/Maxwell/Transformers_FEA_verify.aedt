# Ansys Electronics Desktop project, version 2025.1
materials:
  vacuum: permittivity=1
  TDK_PC95_60cel_BH: core_loss_curve{50kHz (0, 0) (0.049862966, 4.1005345) (0.060258577, 6.8639779) (0.069693025, 9.604843) (0.079288168, 12.85137) (0.089957123, 17.195253) (0.10011968, 22.497801) (0.13429265, 48.181396) (0.19992957, 126.23138) (0.24094943, 202.0447) (0.30010796, 361.71437)} core_loss_curve{100kHz (0, 0) (0.05, 11.750028) (0.059928731, 18.390411) (0.069311536, 26.316823) (0.079506068, 36.825433) (0.090204344, 49.272773) (0.10039483, 64.467157) (0.12000091, 98.665069) (0.15876613, 193.19337) (0.19938163, 330.71604) (0.23897376, 506.15107) (0.29928546, 906.14655)} core_loss_curve{200kHz (0, 0) (0.05, 31.481432) (0.060258577, 50.388871) (0.069693025, 68.947957) (0.079724568, 96.479667) (0.089957123, 129.0907) (0.10067074, 172.72456) (0.13765098, 386.85538) (0.20047902, 947.6625) (0.2490168, 1586.3138) (0.29928546, 2482.7994)} core_loss_curve{300kHz (0, 0) (0.049862966, 63.039229) (0.060093428, 100.89997) (0.069502019, 144.38866) (0.079724568, 197.56947) (0.08971058, 264.3498) (0.10039483, 345.8681) (0.12712013, 605.4819) (0.15446813, 991.08054) (0.19883519, 1897.6238) (0.23963051, 2904.2568) (0.30093272, 4861.5015)} permeability{HUnit=A_per_meter BUnit=tesla curve (0, 0) (17.20430108, 0.079976243) (32.49701314, 0.199539595) (49.70131422, 0.297790055) (64.09402628, 0.349834622) (76.46356033, 0.383911602) (89.84468339, 0.412285451) (107.0489845, 0.436556169) (135.7228196, 0.45174954) (168.2198327, 0.462891344) (202.6284349, 0.471007366) (250.4181601, 0.478084715) (298.2078853, 0.481123389) (498.9247312, 0.486187845) (1282.676225, 0.491252302) (2560, 0.4934)} conductivity=0.167 saturation_mag=0.48tesla core_loss_type="Power Ferrite" core_loss_cm=0.59673882 core_loss_x=1.4941961 core_loss_y=2.4413048 mass_density=4900
  copper: permeability=0.999991 conductivity=58000000
  air: permittivity=1.0006 permeability=1.0000004
  ML91S: permeability{HUnit=A_per_meter BUnit=mTesla curve (0, 0) (10, 15) (20, 29) (30, 44) (40, 59) (50, 75) (60, 92) (70, 111) (80, 134) (90, 160) (100, 187) (120, 251) (140, 303) (160, 345) (180, 382) (200, 410) (250, 451) (300, 472) (350, 485) (400, 494) (450, 500) (500, 505) (600, 514) (700, 519) (800, 523) (900, 526) (1000, 529)} conductivity=0.125 core_loss_type="Power Ferrite" core_loss_cm=0.00649 core_loss_x=1.938 core_loss_y=3.335 mass_density=4850
  TDK_PC95_60cel: core_loss_curve{50kHz (0, 0) (0.049862966, 4.1005345) (0.060258577, 6.8639779) (0.069693025, 9.604843) (0.079288168, 12.85137) (0.089957123, 17.195253) (0.10011968, 22.497801) (0.13429265, 48.181396) (0.19992957, 126.23138) (0.24094943, 202.0447) (0.30010796, 361.71437)} core_loss_curve{100kHz (0, 0) (0.05, 11.750028) (0.059928731, 18.390411) (0.069311536, 26.316823) (0.079506068, 36.825433) (0.090204344, 49.272773) (0.10039483, 64.467157) (0.12000091, 98.665069) (0.15876613, 193.19337) (0.19938163, 330.71604) (0.23897376, 506.15107) (0.29928546, 906.14655)} core_loss_curve{200kHz (0, 0) (0.05, 31.481432) (0.060258577, 50.388871) (0.069693025, 68.947957) (0.079724568, 96.479667) (0.089957123, 129.0907) (0.10067074, 172.72456) (0.13765098, 386.85538) (0.20047902, 947.6625) (0.2490168, 1586.3138) (0.29928546, 2482.7994)} core_loss_curve{300kHz (0, 0) (0.049862966, 63.039229) (0.060093428, 100.89997) (0.069502019, 144.38866) (0.079724568, 197.56947) (0.08971058, 264.3498) (0.10039483, 345.8681) (0.12712013, 605.4819) (0.15446813, 991.08054) (0.19883519, 1897.6238) (0.23963051, 2904.2568) (0.30093272, 4861.5015)} permeability=3700 conductivity=0.167 saturation_mag=0.48tesla core_loss_type="Power Ferrite" core_loss_cm=0.59673882 core_loss_x=1.4941961 core_loss_y=2.4413048 mass_density=4900

design Trans1 (Maxwell 3D, EddyCurrent, model units mm)
variables:
  Lg = 0.2mm
geometry:
  core_1, core [TDK_PC95_60cel] = imported_body(C:\Users\16491\Desktop\HW_Trans\LLC_trans3.sat)
  S_2 [copper] = imported_body(C:\Users\16491\Desktop\HW_Trans\LLC_trans3.sat)
  LLC_trans3_Unnamed_6 = imported_body(C:\Users\16491\Desktop\HW_Trans\LLC_trans3.sat)
  core_3, core_4, core_2 [TDK_PC95_60cel] = imported_body(C:\Users\16491\Desktop\HW_Trans\LLC_trans3.sat)
  P_4 [copper] = imported_body(C:\Users\16491\Desktop\HW_Trans\LLC_trans3.sat)
  LLC_trans3_Unnamed_17 = imported_body(C:\Users\16491\Desktop\HW_Trans\LLC_trans3.sat)
  P_5 [copper] = imported_body(C:\Users\16491\Desktop\HW_Trans\LLC_trans3.sat)
  LLC_trans3_Unnamed_19 = imported_body(C:\Users\16491\Desktop\HW_Trans\LLC_trans3.sat)
  [core_1, core, S_2, LLC_trans3_Unnamed_6, core_3, core_4, core_2, P_4, LLC_trans3_Unnamed_17, P_5, LLC_trans3_Unnamed_19].move(-532.02256mm, -238.98427mm, 0mm)
  [core_1, core, S_2, LLC_trans3_Unnamed_6, core_3, core_4, core_2, P_4, LLC_trans3_Unnamed_17, P_5, LLC_trans3_Unnamed_19].rotate(axis=Z, angle=90deg)
  core_4.sweep_along_vector((0mm, 0mm, 0.003-Lg))
  core.sweep_along_vector((0mm, 0mm, 3mm))
  [core_2, core_3].sweep_along_vector((0mm, 0mm, 0.003-Lg))
  core_1.sweep_along_vector((0mm, 0mm, 3mm))
  P_4.subtract(LLC_trans3_Unnamed_17)
  S_2.subtract(LLC_trans3_Unnamed_19)
  P_5.subtract(LLC_trans3_Unnamed_6)
  S, S_1 [copper] = S_2.duplicate_along_line(step=(0mm, 13.3mm, 4.4408921e-16mm), total=3)
  P, P_1 [copper] = P_4.duplicate_along_line(step=(0mm, 13.3mm, 4.4408921e-16mm), total=3)
  P_2, P_3 [copper] = P_5.duplicate_along_line(step=(0mm, 13.3mm, 4.4408921e-16mm), total=3)
  [S_2, S, S_1].sweep_along_vector((0mm, 0mm, 0.035mm))
  [S_2, S, S_1].move(0mm, 0mm, 2.4mm)
  S_2_1 = S_2.duplicate_along_line(step=(0mm, 0mm, 0.035mm), total=2)
  S_3 = S.duplicate_along_line(step=(0mm, 0mm, 0.035mm), total=2)
  S_1_1 = S_1.duplicate_along_line(step=(0mm, 0mm, 0.035mm), total=2)
  S_2_2 = S_2.duplicate_along_line(step=(0mm, 0mm, -0.035mm), total=2)
  S_4 = S.duplicate_along_line(step=(0mm, 0mm, -0.035mm), total=2)
  S_1_2 = S_1.duplicate_along_line(step=(0mm, 0mm, -0.035mm), total=2)
  S_2_3 [copper] = S_2.duplicate_along_line(step=(0mm, 0mm, -0.4mm), total=2)
  S_5 [copper] = S.duplicate_along_line(step=(0mm, 0mm, -0.4mm), total=2)
  S_1_3 [copper] = S_1.duplicate_along_line(step=(0mm, 0mm, -0.4mm), total=2)
  S_2_4 = S_2.duplicate_along_line(step=(0mm, 0mm, -0.435mm), total=2)
  S_6 = S.duplicate_along_line(step=(0mm, 0mm, -0.435mm), total=2)
  S_1_4 = S_1.duplicate_along_line(step=(0mm, 0mm, -0.435mm), total=2)
  S_1.unite(S_1_1, S_1_2)
  S_1_3.unite(S_1_4)
  S.unite(S_3, S_4)
  S_5.unite(S_6)
  S_2.unite(S_2_1, S_2_2)
  S_2_3.unite(S_2_4)
  [P_4, P_5, P, P_2, P_1, P_3].sweep_along_vector((0mm, 0mm, 0.07mm))
  [P_4, P_5, P, P_2, P_1, P_3].move(0mm, 0mm, 1.6mm)
  S_2_5 [copper] = S_2.duplicate_mirror(point=(0mm, 6.85mm, 1.4mm), normal=(0mm, 0mm, -1mm))
  P_4_1 [copper] = P_4.duplicate_mirror(point=(0mm, 6.85mm, 1.4mm), normal=(0mm, 0mm, -1mm))
  P_5_1 [copper] = P_5.duplicate_mirror(point=(0mm, 6.85mm, 1.4mm), normal=(0mm, 0mm, -1mm))
  S_7 [copper] = S.duplicate_mirror(point=(0mm, 6.85mm, 1.4mm), normal=(0mm, 0mm, -1mm))
  S_1_5 [copper] = S_1.duplicate_mirror(point=(0mm, 6.85mm, 1.4mm), normal=(0mm, 0mm, -1mm))
  P_6 [copper] = P.duplicate_mirror(point=(0mm, 6.85mm, 1.4mm), normal=(0mm, 0mm, -1mm))
  P_1_1 [copper] = P_1.duplicate_mirror(point=(0mm, 6.85mm, 1.4mm), normal=(0mm, 0mm, -1mm))
  P_2_1 [copper] = P_2.duplicate_mirror(point=(0mm, 6.85mm, 1.4mm), normal=(0mm, 0mm, -1mm))
  P_3_1 [copper] = P_3.duplicate_mirror(point=(0mm, 6.85mm, 1.4mm), normal=(0mm, 0mm, -1mm))
  S_2_3_1 [copper] = S_2_3.duplicate_mirror(point=(0mm, 6.85mm, 1.4mm), normal=(0mm, 0mm, -1mm))
  S_5_1 [copper] = S_5.duplicate_mirror(point=(0mm, 6.85mm, 1.4mm), normal=(0mm, 0mm, -1mm))
  S_1_3_1 [copper] = S_1_3.duplicate_mirror(point=(0mm, 6.85mm, 1.4mm), normal=(0mm, 0mm, -1mm))
  core_5 [TDK_PC95_60cel] = box(corner=(-9.5mm, -23.5mm, 3mm), size=(19mm, 47mm, 3mm))
  core_5_1 [TDK_PC95_60cel] = core_5.duplicate_along_line(step=(1.9539925e-14mm, -2.3092639e-13mm, -6mm), total=2)
  S_2_Section1 = S_2.section(plane=YZ)
  P_4_Section1 [copper] = P_4.section(plane=YZ)
  P_5_Section1 [copper] = P_5.section(plane=YZ)
  S_Section1 = S.section(plane=YZ)
  S_1_Section1 = S_1.section(plane=YZ)
  P_Section1 [copper] = P.section(plane=YZ)
  P_1_Section1 [copper] = P_1.section(plane=YZ)
  P_2_Section1 [copper] = P_2.section(plane=YZ)
  P_3_Section1 [copper] = P_3.section(plane=YZ)
  S_2_3_Section1 = S_2_3.section(plane=YZ)
  S_5_Section1 = S_5.section(plane=YZ)
  S_1_3_Section1 = S_1_3.section(plane=YZ)
  S_2_5_Section1 [copper] = S_2_5.section(plane=YZ)
  P_4_1_Section1 [copper] = P_4_1.section(plane=YZ)
  P_5_1_Section1 [copper] = P_5_1.section(plane=YZ)
  S_7_Section1 [copper] = S_7.section(plane=YZ)
  S_1_5_Section1 [copper] = S_1_5.section(plane=YZ)
  P_6_Section1 [copper] = P_6.section(plane=YZ)
  P_1_1_Section1 [copper] = P_1_1.section(plane=YZ)
  P_2_1_Section1 [copper] = P_2_1.section(plane=YZ)
  P_3_1_Section1 [copper] = P_3_1.section(plane=YZ)
  S_2_3_1_Section1 [copper] = S_2_3_1.section(plane=YZ)
  S_5_1_Section1 [copper] = S_5_1.section(plane=YZ)
  S_1_3_1_Section1 [copper] = S_1_3_1.section(plane=YZ)
  S_2_Section1_Separate1 [copper] = S_2_Section1.separate_bodies()
  S_2_Section1.delete()
  P_4_Section1.separate_bodies()
  P_5_Section1.separate_bodies()
  S_Section1_Separate1 [copper] = S_Section1.separate_bodies()
  S_Section1.delete()
  S_1_Section1_Separate1 [copper] = S_1_Section1.separate_bodies()
  S_1_Section1.delete()
  P_Section1.separate_bodies()
  P_1_Section1.separate_bodies()
  P_2_Section1.separate_bodies()
  P_3_Section1.separate_bodies()
  S_2_3_Section1_Separate1 [copper] = S_2_3_Section1.separate_bodies()
  S_2_3_Section1.delete()
  S_5_Section1_Separate1 [copper] = S_5_Section1.separate_bodies()
  S_5_Section1.delete()
  S_1_3_Section1_Separate1 [copper] = S_1_3_Section1.separate_bodies()
  S_1_3_Section1.delete()
  S_2_5_Section1.separate_bodies()
  P_4_1_Section1.separate_bodies()
  P_5_1_Section1.separate_bodies()
  S_7_Section1.separate_bodies()
  S_1_5_Section1.separate_bodies()
  P_6_Section1.separate_bodies()
  P_1_1_Section1.separate_bodies()
  P_2_1_Section1.separate_bodies()
  P_3_1_Section1.separate_bodies()
  S_2_3_1_Section1.separate_bodies()
  S_5_1_Section1.separate_bodies()
  S_1_3_1_Section1.separate_bodies()
  Region [vacuum] = region(percentage_offset: +X=100, -X=100, +Y=50, -Y=50, +Z=200, -Z=200)
  core_Section1 [ML91S] = core.section(plane=YZ)
  core_1_Section1 [ML91S] = core_1.section(plane=YZ)
  core_2_Section1 [ML91S] = core_2.section(plane=YZ)
  core_3_Section1 [ML91S] = core_3.section(plane=YZ)
  core_4_Section1 [ML91S] = core_4.section(plane=YZ)
  core_5_Section1 [ML91S] = core_5.section(plane=YZ)
  core_5_1_Section1 [ML91S] = core_5_1.section(plane=YZ)
  group LLC_trans4 = core_1, core, S_2, core_3, core_4, core_2, P_4, P_5, S, S_1, P, P_1, P_2, P_3, S_2_3, S_5, S_1_3, S_2_5, P_4_1, P_5_1, S_7, S_1_5, P_6, P_1_1, P_2_1, P_3_1, S_2_3_1, S_5_1, S_1_3_1, core_5, core_5_1, P_4_Section1, P_5_Section1, P_Section1, P_1_Section1, P_2_Section1, P_3_Section1, S_2_5_Section1, P_4_1_Section1, P_5_1_Section1, S_7_Section1, S_1_5_Section1, P_6_Section1, P_1_1_Section1, P_2_1_Section1, P_3_1_Section1, S_2_3_1_Section1, S_5_1_Section1, S_1_3_1_Section1, S_2_Section1_Separate1, S_Section1_Separate1, S_1_Section1_Separate1, S_2_3_Section1_Separate1, S_5_Section1_Separate1, S_1_3_Section1_Separate1, core_Section1, core_1_Section1, core_2_Section1, core_3_Section1, core_4_Section1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
boundaries and excitations:
  CoilTerminal_1: Coil Terminal Objects=P_1_Section1 Conductor_number=1 Winding=P Point_out_of_terminal=false
  CoilTerminal_2: Coil Terminal Objects=P_3_Section1 Conductor_number=1 Winding=P Point_out_of_terminal=false
  CoilTerminal_3: Coil Terminal Objects=P_1_1_Section1 Conductor_number=1 Winding=P Point_out_of_terminal=false
  CoilTerminal_4: Coil Terminal Objects=P_3_1_Section1 Conductor_number=1 Winding=P Point_out_of_terminal=false
  CoilTerminal_5: Coil Terminal Objects=P_Section1 Conductor_number=1 Winding=P Point_out_of_terminal=true
  CoilTerminal_6: Coil Terminal Objects=P_2_Section1 Conductor_number=1 Winding=P Point_out_of_terminal=true
  CoilTerminal_7: Coil Terminal Objects=P_6_Section1 Conductor_number=1 Winding=P Point_out_of_terminal=true
  CoilTerminal_8: Coil Terminal Objects=P_2_1_Section1 Conductor_number=1 Winding=P Point_out_of_terminal=true
  CoilTerminal_9: Coil Terminal Objects=P_4_Section1 Conductor_number=1 Winding=P Point_out_of_terminal=false
  CoilTerminal_10: Coil Terminal Objects=P_5_Section1 Conductor_number=1 Winding=P Point_out_of_terminal=false
  CoilTerminal_11: Coil Terminal Objects=P_4_1_Section1 Conductor_number=1 Winding=P Point_out_of_terminal=false
  CoilTerminal_12: Coil Terminal Objects=P_5_1_Section1 Conductor_number=1 Winding=P Point_out_of_terminal=false
  CoilTerminal_13: Coil Terminal Objects=S_1_Section1_Separate1 Conductor_number=1 Winding=S1 Point_out_of_terminal=true
  CoilTerminal_14: Coil Terminal Objects=S_1_3_Section1_Separate1 Conductor_number=1 Winding=S1 Point_out_of_terminal=true
  CoilTerminal_15: Coil Terminal Objects=S_1_5_Section1 Conductor_number=1 Winding=S2 Point_out_of_terminal=true
  CoilTerminal_16: Coil Terminal Objects=S_1_3_1_Section1 Conductor_number=1 Winding=S2 Point_out_of_terminal=true
  CoilTerminal_17: Coil Terminal Objects=S_Section1_Separate1 Conductor_number=1 Winding=S1 Point_out_of_terminal=false
  CoilTerminal_18: Coil Terminal Objects=S_5_Section1_Separate1 Conductor_number=1 Winding=S1 Point_out_of_terminal=false
  CoilTerminal_19: Coil Terminal Objects=S_7_Section1 Conductor_number=1 Winding=S2 Point_out_of_terminal=false
  CoilTerminal_20: Coil Terminal Objects=S_5_1_Section1 Conductor_number=1 Winding=S2 Point_out_of_terminal=false
  CoilTerminal_21: Coil Terminal Objects=S_2_Section1_Separate1 Conductor_number=1 Winding=S1 Point_out_of_terminal=true
  CoilTerminal_22: Coil Terminal Objects=S_2_3_Section1_Separate1 Conductor_number=1 Winding=S1 Point_out_of_terminal=true
  CoilTerminal_23: Coil Terminal Objects=S_2_5_Section1 Conductor_number=1 Winding=S2 Point_out_of_terminal=true
  CoilTerminal_24: Coil Terminal Objects=S_2_3_1_Section1 Conductor_number=1 Winding=S2 Point_out_of_terminal=true
  P: Winding Group Type=Voltage IsSolid=true Current=0mA Resistance=0.01ohm Inductance=0nH Voltage=400V ParallelBranchesNum=1 Phase=0deg
  S1: Winding Group Type=Current IsSolid=true Current=0mA ParallelBranchesNum=3 Phase=0deg
  S2: Winding Group Type=Current IsSolid=true Current=0mA ParallelBranchesNum=3 Phase=0deg
parameters:
  Matrix2: Matrix P, S1, S2:
mesh:
  initial mesh: GlobalCurvilinear{Apply}
setups:
  Setup1: EddyCurrent MaximumPasses=10 MinimumPasses=2 MinimumConvergedPasses=1 PercentRefinement=30 PercentError=1 ConstantDelta=0s NonLinearResidual=0.0001 Frequency=500kHz LossAdaptiveCtrl=0.5

design Trans2 (Maxwell 3D, Transient, model units mm)
options: ComputeTransientInductance
variables:
  Lg = 0.2mm
datasets:
  ip: (0.00199601, -2.782337674) (0.001996015, -2.810468118) (0.00199602, -3.056636359) (0.001996025, -3.067048738) (0.00199603, -2.83649922) (0.001996035, -2.819968358) (0.00199604, -3.043753793) (0.001996045, -3.052633303) (0.00199605, -2.799155027) (0.001996055, -2.853539399) (0.00199606, -2.915511743) (0.001996065, -2.91810062) (0.00199607, -2.861219002) (0.001996075, -2.803840516) (0.00199608, -2.74580924) (0.001996085, -2.687140636) (0.00199609, -2.627850449) (0.001996095, -2.567954425) (0.0019961, -2.507468537) (0.001996105, -2.446408871) (0.00199611, -2.384791514) (0.001996115, -2.322632895) (0.00199612, -2.259949326) (0.001996125, -2.196757464) (0.00199613, -2.133073735) (0.001996135, -2.06891491) (0.00199614, -2.004297926) (0.001996145, -1.939239553) (0.00199615, -1.873756901) (0.001996155, -1.807866909) (0.00199616, -1.741586743) (0.001996165, -1.674933685) (0.00199617, -1.607924958) (0.001996175, -1.540578012) (0.00199618, -1.472910185) (0.001996185, -1.404938871) (0.00199619, -1.336681635) (0.001996195, -1.268156097) (0.0019962, -1.199379824) (0.001996205, -1.130370322) (0.00199621, -1.061145383) (0.001996215, -0.991722629) (0.00199622, -0.922119796) (0.001996225, -0.852354674) (0.00199623, -0.782444886) (0.001996235, -0.71240828) (0.00199624, -0.642262592) (0.001996245, -0.572025556) (0.00199625, -0.501714851) (0.001996255, -0.431348326) (0.00199626, -0.360943602) (0.001996265, -0.290518528) (0.00199627, -0.220090726) (0.001996275, -0.14967776) (0.00199628, -0.079297365) (0.001996285, -0.008967106) (0.00199629, 0.061295509) (0.001996295, 0.131472916) (0.0019963, 0.201547721) (0.001996305, 0.271502415) (0.00199631, 0.341319776) (0.001996315, 0.410982523) (0.00199632, 0.480473375) (0.001996325, 0.549775166) (0.00199633, 0.618870899) (0.001996335, 0.687743579) (0.00199634, 0.756376267) (0.001996345, 0.824752135) (0.00199635, 0.89285453) (0.001996355, 0.960666739) (0.00199636, 1.028172221) (0.001996365, 1.095354662) (0.00199637, 1.162197691) (0.001996375, 1.228684994) (0.00199638, 1.294800654) (0.001996385, 1.360528586) (0.00199639, 1.425852986) (0.001996395, 1.490758109) (0.0019964, 1.555228323) (0.001996405, 1.61924828) (0.00199641, 1.68280269) (0.001996415, 1.745876204) (0.00199642, 1.808453931) (0.001996425, 1.870520975) (0.00199643, 1.93206256) (0.001996435, 1.993064132) (0.00199644, 2.053511366) (0.001996445, 2.113389939) (0.00199645, 2.172685811) (0.001996455, 2.231384997) (0.00199646, 2.289473912) (0.001996465, 2.346938857) (0.00199647, 2.403766473) (0.001996475, 2.459943687) (0.00199648, 2.515457311) (0.001996485, 2.570294669) (0.00199649, 2.624443084) (0.001996495, 2.677890052) (0.0019965, 2.730623464) (0.001996505, 2.78263127) (0.00199651, 2.833901476) (0.001996515, 2.884422656) (0.00199652, 2.934183328) (0.001996525, 2.98317218) (0.00199653, 3.031378355) (0.001996535, 3.078791053) (0.00199654, 3.125399587) (0.001996545, 3.171193782) (0.00199655, 3.216163464) (0.001996555, 3.26029874) (0.00199656, 3.303590006) (0.001996565, 3.346027654) (0.00199657, 3.387602646) (0.001996575, 3.428305945) (0.00199658, 3.468128853) (0.001996585, 3.5070629) (0.00199659, 3.545099673) (0.001996595, 3.582231443) (0.0019966, 3.618450137) (0.001996605, 3.653748365)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
  is1: (0.00199601, -0.340456822) (0.001996015, -0.332162749) (0.00199602, -0.097859889) (0.001996025, -0.094784262) (0.00199603, -0.328317057) (0.001996035, -0.339998117) (0.00199604, -0.103182686) (0.001996045, -0.076581308) (0.00199605, -0.30819357) (0.001996055, -5.98e-06) (0.00199606, 6.65e-06) (0.001996065, 0.080727652) (0.00199607, -2.76e-06) (0.001996075, -1.18e-06) (0.00199608, -3.39e-06) (0.001996085, -1.79e-06) (0.00199609, -4.01e-06) (0.001996095, -2.43e-06) (0.0019961, -4.62e-06) (0.001996105, -3.04e-06) (0.00199611, -5.22e-06) (0.001996115, -3.64e-06) (0.00199612, -5.79e-06) (0.001996125, -4.22e-06) (0.00199613, -6.35e-06) (0.001996135, -4.78e-06) (0.00199614, -6.91e-06) (0.001996145, -5.34e-06) (0.00199615, -7.44e-06) (0.001996155, -5.88e-06) (0.00199616, -7.96e-06) (0.001996165, -6.4e-06) (0.00199617, -8.46e-06) (0.001996175, -6.89e-06) (0.00199618, -8.94e-06) (0.001996185, -7.38e-06) (0.00199619, -9.39e-06) (0.001996195, -7.84e-06) (0.0019962, -9.83e-06) (0.001996205, -8.29e-06) (0.00199621, -1.03e-05) (0.001996215, -8.71e-06) (0.00199622, -1.06e-05) (0.001996225, -9.1e-06) (0.00199623, -1.1e-05) (0.001996235, -9.46e-06) (0.00199624, -1.14e-05) (0.001996245, -9.83e-06) (0.00199625, -1.17e-05) (0.001996255, -1.02e-05) (0.00199626, -1.2e-05) (0.001996265, -1.05e-05) (0.00199627, -1.23e-05) (0.001996275, -1.08e-05) (0.00199628, -1.25e-05) (0.001996285, -1.1e-05) (0.00199629, -1.28e-05) (0.001996295, -1.12e-05) (0.0019963, -1.3e-05) (0.001996305, -1.15e-05) (0.00199631, -1.32e-05) (0.001996315, -1.16e-05) (0.00199632, -1.33e-05) (0.001996325, -1.18e-05) (0.00199633, -1.34e-05) (0.001996335, -1.19e-05) (0.00199634, -1.36e-05) (0.001996345, -1.2e-05) (0.00199635, -1.36e-05) (0.001996355, -1.21e-05) (0.00199636, -1.37e-05) (0.001996365, -1.22e-05) (0.00199637, -1.37e-05) (0.001996375, -1.22e-05) (0.00199638, -1.37e-05) (0.001996385, -1.22e-05) (0.00199639, -1.36e-05) (0.001996395, -1.22e-05) (0.0019964, -1.36e-05) (0.001996405, -1.21e-05) (0.00199641, -1.35e-05) (0.001996415, -1.2e-05) (0.00199642, -1.34e-05) (0.001996425, -1.19e-05) (0.00199643, -1.32e-05) (0.001996435, -1.17e-05) (0.00199644, -1.3e-05) (0.001996445, -1.16e-05) (0.00199645, -1.28e-05) (0.001996455, -1.14e-05) (0.00199646, -1.26e-05) (0.001996465, -1.11e-05) (0.00199647, -1.23e-05) (0.001996475, -1.09e-05) (0.00199648, -1.21e-05) (0.001996485, -1.06e-05) (0.00199649, -1.17e-05) (0.001996495, -1.03e-05) (0.0019965, -1.14e-05) (0.001996505, -9.96e-06) (0.00199651, -1.1e-05) (0.001996515, -9.6e-06) (0.00199652, -1.06e-05) (0.001996525, -9.2e-06) (0.00199653, -1.02e-05) (0.001996535, -8.8e-06) (0.00199654, -9.74e-06) (0.001996545, -8.36e-06) (0.00199655, -9.26e-06) (0.001996555, -7.87e-06) (0.00199656, -8.75e-06) (0.001996565, -7.38e-06) (0.00199657, -8.23e-06) (0.001996575, -6.87e-06) (0.00199658, -7.67e-06) (0.001996585, -6.32e-06) (0.00199659, -7.09e-06) (0.001996595, -5.74e-06) (0.0019966, -6.49e-06) (0.001996605, -5.15e-06)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
  is2: (0.00199601, 0.34046392) (0.001996015, 0.332169854) (0.00199602, 0.09786698) (0.001996025, 0.094791346) (0.00199603, 0.328324163) (0.001996035, 0.340005201) (0.00199604, 0.103189784) (0.001996045, 0.076588393) (0.00199605, 0.308200661) (0.001996055, 0.448070885) (0.00199606, 0.256877215) (0.001996065, 0.266270362) (0.00199607, 0.234376216) (0.001996075, 0.284207573) (0.00199608, 0.335340474) (0.001996085, 0.387751449) (0.00199609, 0.44140149) (0.001996095, 0.496266587) (0.0019961, 0.552307277) (0.001996105, 0.609498947) (0.00199611, 0.667801721) (0.001996115, 0.727190468) (0.00199612, 0.787624892) (0.001996125, 0.849079377) (0.00199613, 0.911513247) (0.001996135, 0.974900473) (0.00199614, 1.039200001) (0.001996145, 1.104385419) (0.00199615, 1.170415352) (0.001996155, 1.237263007) (0.00199616, 1.304886759) (0.001996165, 1.373259451) (0.00199617, 1.442339247) (0.001996175, 1.512098684) (0.00199618, 1.582495699) (0.001996185, 1.653502594) (0.00199619, 1.725077141) (0.001996195, 1.797191366) (0.0019962, 1.869802979) (0.001996205, 1.942883777) (0.00199621, 2.016391399) (0.001996215, 2.090297443) (0.00199622, 2.164559525) (0.001996225, 2.23914914) (0.00199623, 2.314023838) (0.001996235, 2.38915505) (0.00199624, 2.464500348) (0.001996245, 2.540031112) (0.00199625, 2.615704986) (0.001996255, 2.6914933) (0.00199626, 2.767353806) (0.001996265, 2.843257825) (0.00199627, 2.9191633) (0.001996275, 2.995041605) (0.00199628, 3.070850781) (0.001996285, 3.146562307) (0.00199629, 3.222134488) (0.001996295, 3.297538861) (0.0019963, 3.372734007) (0.001996305, 3.447691583) (0.00199631, 3.522370449) (0.001996315, 3.596742516) (0.00199632, 3.670766901) (0.001996325, 3.744415714) (0.00199633, 3.817648469) (0.001996335, 3.890437512) (0.00199634, 3.962742731) (0.001996345, 4.034536779) (0.00199635, 4.105779936) (0.001996355, 4.176445159) (0.00199636, 4.246493233) (0.001996365, 4.315897428) (0.00199637, 4.384619011) (0.001996375, 4.45263165) (0.00199638, 4.519897118) (0.001996385, 4.586389473) (0.00199639, 4.652071091) (0.001996395, 4.716916408) (0.0019964, 4.780888446) (0.001996405, 4.843962074) (0.00199641, 4.906100905) (0.001996415, 4.967280333) (0.00199642, 5.027464603) (0.001996425, 5.086629656) (0.00199643, 5.144740406) (0.001996435, 5.201773327) (0.00199644, 5.257694035) (0.001996445, 5.312479594) (0.00199645, 5.366096367) (0.001996455, 5.41852198) (0.00199646, 5.469723583) (0.001996465, 5.519679434) (0.00199647, 5.568357452) (0.001996475, 5.615736569) (0.00199648, 5.661785501) (0.001996485, 5.706483854) (0.00199649, 5.74980119) (0.001996495, 5.791717804) (0.0019965, 5.832204124) (0.001996505, 5.871241157) (0.00199651, 5.90880024) (0.001996515, 5.944863112) (0.00199652, 5.979401998) (0.001996525, 6.01239941) (0.00199653, 6.043828513) (0.001996535, 6.073672552) (0.00199654, 6.101905718) (0.001996545, 6.128512005) (0.00199655, 6.153466572) (0.001996555, 6.176754248) (0.00199656, 6.198351166) (0.001996565, 6.21824298) (0.00199657, 6.236406833) (0.001996575, 6.252829237) (0.00199658, 6.267488388) (0.001996585, 6.280371601) (0.00199659, 6.291458099) (0.001996595, 6.300736132) (0.0019966, 6.308185945) (0.001996605, 6.313796675)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
geometry:
  core_1, core [TDK_PC95_60cel] = imported_body(C:\Users\16491\Desktop\HW_Trans\LLC_trans3.sat)
  S_2 [copper] = imported_body(C:\Users\16491\Desktop\HW_Trans\LLC_trans3.sat)
  LLC_trans3_Unnamed_6 = imported_body(C:\Users\16491\Desktop\HW_Trans\LLC_trans3.sat)
  core_3, core_4, core_2 [TDK_PC95_60cel] = imported_body(C:\Users\16491\Desktop\HW_Trans\LLC_trans3.sat)
  P_4 [copper] = imported_body(C:\Users\16491\Desktop\HW_Trans\LLC_trans3.sat)
  LLC_trans3_Unnamed_17 = imported_body(C:\Users\16491\Desktop\HW_Trans\LLC_trans3.sat)
  P_5 [copper] = imported_body(C:\Users\16491\Desktop\HW_Trans\LLC_trans3.sat)
  LLC_trans3_Unnamed_19 = imported_body(C:\Users\16491\Desktop\HW_Trans\LLC_trans3.sat)
  [core_1, core, S_2, LLC_trans3_Unnamed_6, core_3, core_4, core_2, P_4, LLC_trans3_Unnamed_17, P_5, LLC_trans3_Unnamed_19].move(-532.02256mm, -238.98427mm, 0mm)
  [core_1, core, S_2, LLC_trans3_Unnamed_6, core_3, core_4, core_2, P_4, LLC_trans3_Unnamed_17, P_5, LLC_trans3_Unnamed_19].rotate(axis=Z, angle=90deg)
  core_4.sweep_along_vector((0mm, 0mm, 0.003-Lg))
  core.sweep_along_vector((0mm, 0mm, 3mm))
  [core_2, core_3].sweep_along_vector((0mm, 0mm, 0.003-Lg))
  core_1.sweep_along_vector((0mm, 0mm, 3mm))
  P_4.subtract(LLC_trans3_Unnamed_17)
  S_2.subtract(LLC_trans3_Unnamed_19)
  P_5.subtract(LLC_trans3_Unnamed_6)
  S, S_1 [copper] = S_2.duplicate_along_line(step=(0mm, 13.3mm, 4.4408921e-16mm), total=3)
  P, P_1 [copper] = P_4.duplicate_along_line(step=(0mm, 13.3mm, 4.4408921e-16mm), total=3)
  P_2, P_3 [copper] = P_5.duplicate_along_line(step=(0mm, 13.3mm, 4.4408921e-16mm), total=3)
  [S_2, S, S_1].sweep_along_vector((0mm, 0mm, 0.035mm))
  [S_2, S, S_1].move(0mm, 0mm, 2.4mm)
  S_2_1 = S_2.duplicate_along_line(step=(0mm, 0mm, 0.035mm), total=2)
  S_3 = S.duplicate_along_line(step=(0mm, 0mm, 0.035mm), total=2)
  S_1_1 = S_1.duplicate_along_line(step=(0mm, 0mm, 0.035mm), total=2)
  S_2_2 = S_2.duplicate_along_line(step=(0mm, 0mm, -0.035mm), total=2)
  S_4 = S.duplicate_along_line(step=(0mm, 0mm, -0.035mm), total=2)
  S_1_2 = S_1.duplicate_along_line(step=(0mm, 0mm, -0.035mm), total=2)
  S_2_3 [copper] = S_2.duplicate_along_line(step=(0mm, 0mm, -0.4mm), total=2)
  S_5 [copper] = S.duplicate_along_line(step=(0mm, 0mm, -0.4mm), total=2)
  S_1_3 [copper] = S_1.duplicate_along_line(step=(0mm, 0mm, -0.4mm), total=2)
  S_2_4 = S_2.duplicate_along_line(step=(0mm, 0mm, -0.435mm), total=2)
  S_6 = S.duplicate_along_line(step=(0mm, 0mm, -0.435mm), total=2)
  S_1_4 = S_1.duplicate_along_line(step=(0mm, 0mm, -0.435mm), total=2)
  S_1.unite(S_1_1, S_1_2)
  S_1_3.unite(S_1_4)
  S.unite(S_3, S_4)
  S_5.unite(S_6)
  S_2.unite(S_2_1, S_2_2)
  S_2_3.unite(S_2_4)
  [P_4, P_5, P, P_2, P_1, P_3].sweep_along_vector((0mm, 0mm, 0.07mm))
  [P_4, P_5, P, P_2, P_1, P_3].move(0mm, 0mm, 1.6mm)
  S_2_5 [copper] = S_2.duplicate_mirror(point=(0mm, 6.85mm, 1.4mm), normal=(0mm, 0mm, -1mm))
  P_4_1 [copper] = P_4.duplicate_mirror(point=(0mm, 6.85mm, 1.4mm), normal=(0mm, 0mm, -1mm))
  P_5_1 [copper] = P_5.duplicate_mirror(point=(0mm, 6.85mm, 1.4mm), normal=(0mm, 0mm, -1mm))
  S_7 [copper] = S.duplicate_mirror(point=(0mm, 6.85mm, 1.4mm), normal=(0mm, 0mm, -1mm))
  S_1_5 [copper] = S_1.duplicate_mirror(point=(0mm, 6.85mm, 1.4mm), normal=(0mm, 0mm, -1mm))
  P_6 [copper] = P.duplicate_mirror(point=(0mm, 6.85mm, 1.4mm), normal=(0mm, 0mm, -1mm))
  P_1_1 [copper] = P_1.duplicate_mirror(point=(0mm, 6.85mm, 1.4mm), normal=(0mm, 0mm, -1mm))
  P_2_1 [copper] = P_2.duplicate_mirror(point=(0mm, 6.85mm, 1.4mm), normal=(0mm, 0mm, -1mm))
  P_3_1 [copper] = P_3.duplicate_mirror(point=(0mm, 6.85mm, 1.4mm), normal=(0mm, 0mm, -1mm))
  S_2_3_1 [copper] = S_2_3.duplicate_mirror(point=(0mm, 6.85mm, 1.4mm), normal=(0mm, 0mm, -1mm))
  S_5_1 [copper] = S_5.duplicate_mirror(point=(0mm, 6.85mm, 1.4mm), normal=(0mm, 0mm, -1mm))
  S_1_3_1 [copper] = S_1_3.duplicate_mirror(point=(0mm, 6.85mm, 1.4mm), normal=(0mm, 0mm, -1mm))
  core_5 [TDK_PC95_60cel] = box(corner=(-9.5mm, -23.5mm, 3mm), size=(19mm, 47mm, 3mm))
  core_5_1 [TDK_PC95_60cel] = core_5.duplicate_along_line(step=(1.9539925e-14mm, -2.3092639e-13mm, -6mm), total=2)
  S_2_Section1 = S_2.section(plane=YZ)
  P_4_Section1 [copper] = P_4.section(plane=YZ)
  P_5_Section1 [copper] = P_5.section(plane=YZ)
  S_Section1 = S.section(plane=YZ)
  S_1_Section1 = S_1.section(plane=YZ)
  P_Section1 [copper] = P.section(plane=YZ)
  P_1_Section1 [copper] = P_1.section(plane=YZ)
  P_2_Section1 [copper] = P_2.section(plane=YZ)
  P_3_Section1 [copper] = P_3.section(plane=YZ)
  S_2_3_Section1 = S_2_3.section(plane=YZ)
  S_5_Section1 = S_5.section(plane=YZ)
  S_1_3_Section1 = S_1_3.section(plane=YZ)
  S_2_5_Section1 [copper] = S_2_5.section(plane=YZ)
  P_4_1_Section1 [copper] = P_4_1.section(plane=YZ)
  P_5_1_Section1 [copper] = P_5_1.section(plane=YZ)
  S_7_Section1 [copper] = S_7.section(plane=YZ)
  S_1_5_Section1 [copper] = S_1_5.section(plane=YZ)
  P_6_Section1 [copper] = P_6.section(plane=YZ)
  P_1_1_Section1 [copper] = P_1_1.section(plane=YZ)
  P_2_1_Section1 [copper] = P_2_1.section(plane=YZ)
  P_3_1_Section1 [copper] = P_3_1.section(plane=YZ)
  S_2_3_1_Section1 [copper] = S_2_3_1.section(plane=YZ)
  S_5_1_Section1 [copper] = S_5_1.section(plane=YZ)
  S_1_3_1_Section1 [copper] = S_1_3_1.section(plane=YZ)
  S_2_Section1_Separate1 [copper] = S_2_Section1.separate_bodies()
  S_2_Section1.delete()
  P_4_Section1.separate_bodies()
  P_5_Section1.separate_bodies()
  S_Section1_Separate1 [copper] = S_Section1.separate_bodies()
  S_Section1.delete()
  S_1_Section1_Separate1 [copper] = S_1_Section1.separate_bodies()
  S_1_Section1.delete()
  P_Section1.separate_bodies()
  P_1_Section1.separate_bodies()
  P_2_Section1.separate_bodies()
  P_3_Section1.separate_bodies()
  S_2_3_Section1_Separate1 [copper] = S_2_3_Section1.separate_bodies()
  S_2_3_Section1.delete()
  S_5_Section1_Separate1 [copper] = S_5_Section1.separate_bodies()
  S_5_Section1.delete()
  S_1_3_Section1_Separate1 [copper] = S_1_3_Section1.separate_bodies()
  S_1_3_Section1.delete()
  S_2_5_Section1.separate_bodies()
  P_4_1_Section1.separate_bodies()
  P_5_1_Section1.separate_bodies()
  S_7_Section1.separate_bodies()
  S_1_5_Section1.separate_bodies()
  P_6_Section1.separate_bodies()
  P_1_1_Section1.separate_bodies()
  P_2_1_Section1.separate_bodies()
  P_3_1_Section1.separate_bodies()
  S_2_3_1_Section1.separate_bodies()
  S_5_1_Section1.separate_bodies()
  S_1_3_1_Section1.separate_bodies()
  Region [vacuum] = region(percentage_offset: +X=100, -X=100, +Y=50, -Y=50, +Z=200, -Z=200)
  core_Section1 [ML91S] = core.section(plane=YZ)
  core_1_Section1 [ML91S] = core_1.section(plane=YZ)
  core_2_Section1 [ML91S] = core_2.section(plane=YZ)
  core_3_Section1 [ML91S] = core_3.section(plane=YZ)
  core_4_Section1 [ML91S] = core_4.section(plane=YZ)
  core_5_Section1 [ML91S] = core_5.section(plane=YZ)
  core_5_1_Section1 [ML91S] = core_5_1.section(plane=YZ)
  group LLC_trans4 = core_1, core, S_2, core_3, core_4, core_2, P_4, P_5, S, S_1, P, P_1, P_2, P_3, S_2_3, S_5, S_1_3, S_2_5, P_4_1, P_5_1, S_7, S_1_5, P_6, P_1_1, P_2_1, P_3_1, S_2_3_1, S_5_1, S_1_3_1, core_5, core_5_1, P_4_Section1, P_5_Section1, P_Section1, P_1_Section1, P_2_Section1, P_3_Section1, S_2_5_Section1, P_4_1_Section1, P_5_1_Section1, S_7_Section1, S_1_5_Section1, P_6_Section1, P_1_1_Section1, P_2_1_Section1, P_3_1_Section1, S_2_3_1_Section1, S_5_1_Section1, S_1_3_1_Section1, S_2_Section1_Separate1, S_Section1_Separate1, S_1_Section1_Separate1, S_2_3_Section1_Separate1, S_5_Section1_Separate1, S_1_3_Section1_Separate1, core_Section1, core_1_Section1, core_2_Section1, core_3_Section1, core_4_Section1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
boundaries and excitations:
  CoilTerminal_1: Coil Terminal Objects=P_1_Section1 Conductor_number=1 Winding=P Point_out_of_terminal=false
  CoilTerminal_2: Coil Terminal Objects=P_3_Section1 Conductor_number=1 Winding=P Point_out_of_terminal=false
  CoilTerminal_3: Coil Terminal Objects=P_1_1_Section1 Conductor_number=1 Winding=P Point_out_of_terminal=false
  CoilTerminal_4: Coil Terminal Objects=P_3_1_Section1 Conductor_number=1 Winding=P Point_out_of_terminal=false
  CoilTerminal_5: Coil Terminal Objects=P_Section1 Conductor_number=1 Winding=P Point_out_of_terminal=true
  CoilTerminal_6: Coil Terminal Objects=P_2_Section1 Conductor_number=1 Winding=P Point_out_of_terminal=true
  CoilTerminal_7: Coil Terminal Objects=P_6_Section1 Conductor_number=1 Winding=P Point_out_of_terminal=true
  CoilTerminal_8: Coil Terminal Objects=P_2_1_Section1 Conductor_number=1 Winding=P Point_out_of_terminal=true
  CoilTerminal_9: Coil Terminal Objects=P_4_Section1 Conductor_number=1 Winding=P Point_out_of_terminal=false
  CoilTerminal_10: Coil Terminal Objects=P_5_Section1 Conductor_number=1 Winding=P Point_out_of_terminal=false
  CoilTerminal_11: Coil Terminal Objects=P_4_1_Section1 Conductor_number=1 Winding=P Point_out_of_terminal=false
  CoilTerminal_12: Coil Terminal Objects=P_5_1_Section1 Conductor_number=1 Winding=P Point_out_of_terminal=false
  CoilTerminal_13: Coil Terminal Objects=S_1_Section1_Separate1 Conductor_number=1 Winding=S1 Point_out_of_terminal=false
  CoilTerminal_14: Coil Terminal Objects=S_1_3_Section1_Separate1 Conductor_number=1 Winding=S1 Point_out_of_terminal=false
  CoilTerminal_15: Coil Terminal Objects=S_1_5_Section1 Conductor_number=1 Winding=S2 Point_out_of_terminal=false
  CoilTerminal_16: Coil Terminal Objects=S_1_3_1_Section1 Conductor_number=1 Winding=S2 Point_out_of_terminal=false
  CoilTerminal_17: Coil Terminal Objects=S_Section1_Separate1 Conductor_number=1 Winding=S1 Point_out_of_terminal=true
  CoilTerminal_18: Coil Terminal Objects=S_5_Section1_Separate1 Conductor_number=1 Winding=S1 Point_out_of_terminal=true
  CoilTerminal_19: Coil Terminal Objects=S_7_Section1 Conductor_number=1 Winding=S2 Point_out_of_terminal=true
  CoilTerminal_20: Coil Terminal Objects=S_5_1_Section1 Conductor_number=1 Winding=S2 Point_out_of_terminal=true
  CoilTerminal_21: Coil Terminal Objects=S_2_Section1_Separate1 Conductor_number=1 Winding=S1 Point_out_of_terminal=false
  CoilTerminal_22: Coil Terminal Objects=S_2_3_Section1_Separate1 Conductor_number=1 Winding=S1 Point_out_of_terminal=false
  CoilTerminal_23: Coil Terminal Objects=S_2_5_Section1 Conductor_number=1 Winding=S2 Point_out_of_terminal=false
  CoilTerminal_24: Coil Terminal Objects=S_2_3_1_Section1 Conductor_number=1 Winding=S2 Point_out_of_terminal=false
  P: Winding Group Type=Current IsSolid=true Current=pwl_periodic(ip,time) ParallelBranchesNum=1
  S1: Winding Group Type=Current IsSolid=true Current=pwl_periodic(is1,time) ParallelBranchesNum=3
  S2: Winding Group Type=Current IsSolid=true Current=pwl_periodic(is2,time) ParallelBranchesNum=3
  eddy effects on: S_2, P_4, P_5, S, S_1, P, P_1, P_2, P_3, S_2_3, S_5, S_1_3, S_2_5, P_4_1, P_5_1, S_7, S_1_5, P_6, P_1_1, P_2_1, P_3_1, S_2_3_1, S_5_1, S_1_3_1
  core loss on: core_1, core, core_3, core_4, core_2, core_5, core_5_1
mesh:
  initial mesh: GlobalCurvilinear{Apply}
setups:
  Setup1: Transient MeshLink{ImportMesh LinkID=417 Project="This Project*" Product="Maxwell 3D" Design=Trans1 Params{Lg=0.2mm} ForceSourceToSolve PathRelativeTo=TargetProject ApplyMeshOp} NonlinearSolverResidual=0.005 ScalarPotential="Second Order" StopTime=4us TimeStep=10ns SaveFieldsType="Every N Steps" N_Steps=1 Steps_From=0s Steps_To=4us NumberSolveSteps=1 RangeStart=0s RangeEnd=0.1s
